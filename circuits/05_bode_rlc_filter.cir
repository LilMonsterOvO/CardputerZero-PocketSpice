* @title: RLC Filter Bode
* @title_zh: 二阶 RLC 滤波 (Bode)
* @desc: Second-order LC low-pass filter AC sweep (demonstrates .ac Bode mode)
* @param: L_uH | 100.0 | 10.0 | 1000.0 | 20.0 | uH | Filter inductor
* @param: C_uF | 10.0 | 1.0 | 100.0 | 2.0 | uF | Filter capacitor
* @param: R_load | 10.0 | 1.0 | 200.0 | 5.0 | ohm | Load resistance
* @signals: v(out)

V_in in 0 DC 0 AC 1
L1 in out {L_uH}u
R_esr out c_n 0.05
C1 c_n 0 {C_uF}u
R_load out 0 {R_load}

.ac dec 40 100 200k
.save v(out)
.end
